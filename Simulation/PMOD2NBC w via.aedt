# Ansys Electronics Desktop project, version 2023.2
materials:
  vacuum: permittivity=1
  copper: permeability=0.999991 conductivity=58000000
  FR4_epoxy: permittivity=4.4 dielectric_loss_tangent=0.02

design HFSSDesign1 (HFSS, HFSS Modal Network, model units mm)
geometry:
  SIGNAL_LINE [copper] = box(corner=(9.83mm, 0mm, 0.232mm), size=(0.34mm, 40mm, 0.055mm))
  RAD [vacuum] = box(corner=(4.5mm, 0mm, -2mm), size=(11mm, 40mm, 5mm))
  Rectangle1 = rectangle(corner=(12mm, 0mm, 1mm), z_size=-1.4mm, x_size=-3.8mm)
  Cylinder2 = cylinder(axis=Z, base_centre=(11.26238mm, 0.5mm, 0mm), radius=0.2mm, height=0.287mm)
  via [copper] = cylinder(axis=Z, base_centre=(11.26238mm, 0.5mm, 0mm), radius=0.254mm, height=0.287mm)
  via_1 = via.copy()
  via_1.delete()
  via_2 = via.copy()
  via_2.delete()
  via.subtract(Cylinder2)
  Substrate [FR4_epoxy] = imported_body()
  Box2, Cylinder17 = imported_body()
  Cylinder17.unite(Box2)
  via.unite(Cylinder17)
boundaries and excitations:
  PerfE1: Perfect E Objects=SIGNAL_LINE
  Rad1: Radiation Objects=RAD
  1: Wave Port Objects=Rectangle1 WavePortType=Default NumModes=1 Modes{Mode1{IntLine{(10, 0, 0.287) -> (10, 0, 0)} CharImp=Zpi}}
setups:
  Setup1: HfssDrivenAuto AutoSolverSetting=Balanced SaveAnyFields=false Type=Interpolating
    sweep Sweep: 0GHz to 10GHz, 501 points;
source amplitudes:
  1:1: 1W 0deg
reports:
  Port Zo Plot 1: mag(Zo(1)) vs Freq on Setup1 : Sweep
